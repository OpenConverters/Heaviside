* SRC Series Resonant Converter v0.1 (Behavioural PULSE bridge, separate Lr)
* Half-Bridge, full-bridge diode rectifier
* Vin=48V  fsw=200kHz  outputs=1
* Lr=14.3005uH  Cr=59.0429nF  Lpri=1000uH
*   output 0: Vout=12V Iout=5A n=2

Vdc_supply vdc_supply 0 48
Rdc_supply_dummy vdc_supply 0 1Meg

.model SW1 SW VT=2.500000 VH=0.100000 RON=0.050000 RON=0.01 ROFF=1e+06
.model DIDEAL D(IS=1.000000e-12 RS=5.000000e-02)

Cbus_hi vdc_supply mid_point 1u IC=24
Cbus_lo mid_point 0 1u IC=24
Rbal_hi vdc_supply mid_point 100k
Rbal_lo mid_point 0 100k
Vpwm_HI pwm_HI 0 PULSE(0 5 0 1.000000e-08 1.000000e-08 2.475000e-06 5.000000e-06)
Vpwm_LO pwm_LO 0 PULSE(0 5.000000 2.500000e-06 1.000000e-08 1.000000e-08 2.475000e-06 5.000000e-06)
SHI vdc_supply sw_node pwm_HI 0 SW1
DHI 0 sw_node DIDEAL
SLO sw_node 0 pwm_LO 0 SW1
DLO sw_node vdc_supply DIDEAL
Rsnub_HI vdc_supply sw_node 10000.000000
Csnub_HI vdc_supply sw_node 1.000000e-10
Rsnub_LO sw_node 0 10000.000000
Csnub_LO sw_node 0 1.000000e-10
Vpri_sense sw_node cr_in 0

* Resonant tank (separate Lr)
Cr cr_in cr_lr  5.904295e-08
Lr cr_lr pri_top 1.430049e-05

Lpri pri_top pri_bot 1.000000e-03
Lsec_o1 sec_pos_sec_o1 sec_neg_sec_o1 2.500000e-04
K1 Lpri Lsec_o1 9.990000e-01

Rpri_ret pri_bot mid_point 0.001

.model DRECT D(Is=1e-8 N=0.01 RS=0.01)
* Output 1 (FB diode rectifier, Vout=1.200000e+01V Rload=2.400000e+00)
Dh1_o1 sec_pos_o1 vout_pos_o1 DRECT
Dh2_o1 sec_neg_o1 vout_pos_o1 DRECT
Dl1_o1 vout_neg_o1 sec_pos_o1 DRECT
Dl2_o1 vout_neg_o1 sec_neg_o1 DRECT
Rsnh1_o1 sec_pos_o1 vout_pos_o1 100
Csnh1_o1 sec_pos_o1 vout_pos_o1 100p
Rsnh2_o1 sec_neg_o1 vout_pos_o1 100
Csnh2_o1 sec_neg_o1 vout_pos_o1 100p
Vsec_sense_o1 sec_pos_sec_o1 sec_pos_o1 0
Vsec_ret_o1 sec_neg_o1 sec_neg_sec_o1 0
Vgnd_o1 vout_neg_o1 0 0
Resr_o1 vout_pos_o1 vout_cap_o1 0.05
Cout_o1 vout_cap_o1 vout_neg_o1 4.700000e-05
Rload_o1 vout_cap_o1 vout_neg_o1 2.400000e+00

.ic v(vout_cap_o1)=1.200000e+01 v(cr_lr)=0

.options RELTOL=1.000000e-02 ABSTOL=1.000000e-07 VNTOL=1.000000e-04 ITL1=500 ITL4=500
.options METHOD=GEAR TRTOL=7.000000

.tran 2.500000e-08 7.500000e-05 5.000000e-05 2.500000e-08 UIC

.save v(vdc_supply) i(Vdc_supply) v(pri_top) v(pri_bot) i(Vpri_sense) v(sw_node) v(mid_point) v(sec_pos_o1) v(sec_neg_o1) v(vout_pos_o1) v(vout_cap_o1) i(Vsec_sense_o1)

.end

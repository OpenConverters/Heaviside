* SEPIC Converter (V1 uncoupled) - Generated by OpenMagnetics
* Vin=48V, Vo=12V, f=200kHz, D=21.7839 pct
* L1=1000uH, L2=34.8542uH, Cs=2.26915uF, Co=7.8125uF, Iout=5A

* DC Input + sense
Vin vin_dc 0 48
Vin_sense vin_dc l1_in 0

* L1 input inductor (with DCR)
L1 l1_in l1_dcr_mid 1.000000e-03 ic=1.392544
Rdcr_l1 l1_dcr_mid node_A 0.050000
Vl1_sense node_A node_A_int 0

* PWM low-side switch on node_A
Vpwm pwm_ctrl 0 PULSE(0 5.000000 0 1.000000e-08 1.000000e-08 1.089194e-06 5.000000e-06)
.model SW1 SW VT=2.500000 VH=0.100000 RON=0.050000
S1 node_A_int 0 pwm_ctrl 0 SW1
Rsnub_s1 node_A_int 0 10000.000000
Csnub_s1 node_A_int snub_s1_int 1.000000e-10
Rsnub_s1b snub_s1_int 0 10000.000000

* Cs coupling cap (with ESR; +plate at node_A side, IC=Vin)
Vc_sense node_A_int node_C 0
Cs node_C node_C_esr 2.269154e-06 ic=48.000000
Rcs_esr node_C_esr node_B 0.005000

* L2 inductor (bottom-side at GND; with DCR)
L2 0 l2_top 3.485420e-05 ic=5.000000
Rdcr_l2 l2_top node_B 0.050000
Vl2_sense node_B node_B_int 0

Vd_sense d_anode 0 0
* D1 rectifier diode
.model DIDEAL D(IS=1.000000e-12 RS=5.000000e-02)
Vrect_sense node_B_int rect_in 0
D1 rect_in vout DIDEAL
Rsnub_d1 rect_in 0 10000.000000
Csnub_d1 rect_in snub_d1_int 1.000000e-10
Rsnub_d1b snub_d1_int 0 10000.000000

* Output cap (with ESR) and resistive load
Cout vout co_esr 7.812500e-06 ic=12.000000
Rco_esr co_esr 0 0.005000
Vout_sense vout vout_load 0
Rload vout_load 0 2.400000

* Bridge / switch-node probe
Bsw sw_probe 0 V=V(node_A)
Bvpri_diff vpri_diff 0 V=V(l1_in)-V(node_A)

* Transient Analysis (UIC enables .ic above)
.tran 2.500000e-08 2.750000e-04 2.500000e-04 UIC

* Output signals
.save v(vpri_diff) v(vin_dc) v(node_A) v(node_B) v(sw_probe) v(vout) i(Vin_sense) i(Vl1_sense) i(Vc_sense) i(Vl2_sense) i(Vrect_sense) i(Vout_sense)

.options RELTOL=0.010000 ABSTOL=1.000000e-07 VNTOL=1.000000e-04 ITL1=500 ITL4=500
.options METHOD=GEAR TRTOL=7.000000
.end

* Flyback Converter - Generated by OpenMagnetics
* Vin=48V, f=200kHz, D=34.4828 pct
* Lp=1000uH, N1=2, 1 secondaries

* DC Input
Vin vin_dc 0 48

* PWM Switch
Vpwm pwm_ctrl 0 PULSE(0 5 0 1.000000e-08 1.000000e-08 1.724138e-06 5.000000e-06)
.model SW1 SW VT=2.500000 VH=0.500000
S1 vin_dc pri_p pwm_ctrl 0 SW1
Rsnub_s1 vin_dc pri_p 10000.000000
Csnub_s1 vin_dc pri_p 1.000000e-10

* Primary current sense
Vpri_sense pri_p pri_in 0

* Flyback Transformer - Primary and 1 secondaries
Lpri pri_in 0 1.000000e-03
Lsec0 0 sec0_in 2.500000e-04
K0 Lpri Lsec0 1

* Output Rectifier model
.model DIDEAL D(IS=1.000000e-12 RS=5.000000e-02)

* Secondary 0 output stage
Dout0 sec0_in sec0_p DIDEAL
Vsec_sense0 sec0_p vout0 0
Cout0 vout0 0 1.000000e-05 IC=12.000000
Rload0 vout0 0 6.000000

* Transient Analysis
.tran 2.500000e-08 5.000000e-05 2.500000e-05

* Output signals
.save v(pri_in) v(vin_dc) v(sec0_in) v(vout0) i(Vsec_sense0) i(Vpri_sense)

.options RELTOL=0.001000 ABSTOL=1.000000e-09 VNTOL=1.000000e-06 ITL1=1000 ITL4=1000
.options METHOD=GEAR TRTOL=7.000000
.ic v(vout0)=12.000000

.end

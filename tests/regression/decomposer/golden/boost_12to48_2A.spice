* Boost Converter - Generated by OpenMagnetics
* Vin=12V, Vout=48V, f=200kHz, D=76.5914 pct
* L=33uH, Iout=2A

* DC Input
Vin vin_dc 0 12

* Inductor with current sense
Vl_sense vin_dc l_in 0
L1 l_in sw 3.300000e-05 IC=8.116667
Bvpri_diff vpri_diff 0 V=V(l_in)-V(sw)

* PWM Low-side Switch
Vpwm pwm_ctrl 0 PULSE(0 5.000000 0 1.000000e-08 1.000000e-08 3.829569e-06 5.000000e-06)
.model SW1 SW VT=2.500000 VH=0.500000 RON=0.010000 ROFF=1000000.000000
S1 sw 0 pwm_ctrl 0 SW1
Rsnub_s1 sw 0 10000.000000
Csnub_s1 sw 0 1.000000e-10

* Output Diode
.model DIDEAL D(IS=1.000000e-12 RS=5.000000e-02)
D1 sw vout DIDEAL

* Output Filter and Load
Cout vout 0 1.000000e-04 IC=48.000000
Rload vout 0 24.000000

* Transient Analysis
.tran 2.500000e-08 2.750000e-04 2.500000e-04 UIC

* Output signals
.save v(vpri_diff) v(vin_dc) v(sw) v(vout) i(Vl_sense)

.options RELTOL=0.001000 ABSTOL=1.000000e-09 VNTOL=1.000000e-06 ITL1=1000 ITL4=1000
.options METHOD=GEAR TRTOL=7.000000
.ic v(vout)=48.000000

.end

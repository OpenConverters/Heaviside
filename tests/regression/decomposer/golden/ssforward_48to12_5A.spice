* Single-Switch Forward Converter - Generated by OpenMagnetics
* Vin=48V, f=200kHz, D=26.4583 pct
* Lmag=1000uH, 0 secondaries

* DC Input
Vin vin_dc 0 48

* §8a.5 input-current sense
Vq1_sense vin_dc q1_drain 0

* PWM Main Switch
Vpwm pwm_ctrl 0 PULSE(0 5 0 1e-08 1e-08 1.32292e-06 5e-06)
.model SW1 SW VT=2.5 VH=0.5 RON=1 ROFF=1.000000e+12
S1 q1_drain pri_p pwm_ctrl 0 SW1

* Primary current sense
Vpri_sense pri_p pri_in 0

* Forward Transformer
Lpri pri_in 0 1.000000e-03
Ldemag 0 demag_in 1.000000e-03
* Coupling: All windings coupled pairwise
Kpri_demag Lpri Ldemag 0.9999

* Demagnetization Diode and current sense
.model DIDEAL D(IS=1.000000e-12 RS=5.000000e-02)
Vdemag_sense demag_in demag_sense 0
Ddemag demag_sense vin_dc DIDEAL

* Transient Analysis
.tran 2.500000e-08 5.000000e-05 2.500000e-05

* Output signals
.save v(pri_in) i(Vpri_sense) v(demag_in) i(Vdemag_sense) v(vin_dc) i(Vin) i(Vq1_sense)

.options RELTOL=0.001000 ABSTOL=1.000000e-09 VNTOL=1.000000e-06 ITL1=1000 ITL4=1000

.end

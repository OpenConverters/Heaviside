* Single-Switch Forward Converter - Generated by OpenMagnetics
* Vin=48V, f=200kHz, D=42.3333 pct
* Lmag=1000uH, 1 secondaries

* DC Input
Vin vin_dc 0 48

* §8a.5 input-current sense
Vq1_sense vin_dc q1_drain 0

* PWM Main Switch
Vpwm pwm_ctrl 0 PULSE(0 5 0 1e-08 1e-08 2.11667e-06 5e-06)
.model SW1 SW VT=2.500000 VH=0.100000 RON=0.050000 RON=1 ROFF=1.000000e+12
S1 q1_drain pri_p pwm_ctrl 0 SW1

* Primary current sense
Vpri_sense pri_p pri_in 0

* Forward Transformer
Lpri pri_in 0 1.000000e-03
Ldemag 0 demag_in 1.000000e-03
Lsec0 sec0_in 0 3.906250e-04
* Coupling: All windings coupled pairwise
Kpri_demag Lpri Ldemag 0.9999
Kpri_sec0 Lpri Lsec0 0.9999
Kdemag_sec0 Ldemag Lsec0 0.9999

* Demagnetization Diode and current sense
.model DIDEAL D(IS=1.000000e-12 RS=5.000000e-02)
Vdemag_sense demag_in demag_sense 0
Ddemag demag_sense vin_dc DIDEAL

* Secondary 0 output stage
Dfwd0 sec0_in sec0_rect DIDEAL
Dfw0 0 sec0_rect DIDEAL
Rsnub_fwd0 sec0_in sec0_rect 10000.000000MEG
Rsnub_fw0 0 sec0_rect 10000.000000MEG
Vsec_sense0 sec0_rect sec0_l_in 0
Rlout0 sec0_l_in lout0 0.01
Lout0 lout0 vout_c0 9.731250e-05
Rcout0 vout_c0 vout0 0.1
Cout0 vout0 0 100u IC=12.000000
Rload0 vout0 0 2.400000

* Transient Analysis
.tran 2.500000e-08 5.000000e-05 2.500000e-05

* Output signals
.save v(pri_in) i(Vpri_sense) v(demag_in) i(Vdemag_sense) v(vin_dc) i(Vin) i(Vq1_sense) v(sec0_in) i(Vsec_sense0) v(vout0)

.options RELTOL=0.001000 ABSTOL=1.000000e-09 VNTOL=1.000000e-06 ITL1=1000 ITL4=1000
.ic v(vout0)=12

.end

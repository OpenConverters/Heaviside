* Buck Converter - Generated by OpenMagnetics
* Vin=48V, Vout=12V, f=200kHz, D=27.4506 pct
* L=22uH, Iout=5A

* DC Input
Vin vin_src 0 48
Vin_sense vin_src vin_dc 0

* PWM High-side Switch
Vpwm pwm_ctrl 0 PULSE(0 5 0 1.000000e-08 1.000000e-08 1.372528e-06 5.000000e-06)
.model SW1 SW VT=2.500000 VH=0.100000 RON=0.050000
S1 vin_dc sw pwm_ctrl 0 SW1
Rsnub_s1 vin_dc sw 10000.000000
Csnub_s1 vin_dc sw 1.000000e-10

* Freewheeling Diode
.model DIDEAL D(IS=1.000000e-12 RS=5.000000e-02)
D1 0 sw DIDEAL

* Inductor with current sense
Vl_sense sw l_in 0
L1 l_in vout 2.200000e-05
Bvpri_diff vpri_diff 0 V=V(l_in)-V(vout)

* Output Filter and Load
Cout vout 0 1.000000e-04 IC=12.000000
Rload vout 0 2.400000

* Transient Analysis
.tran 2.500000e-08 2.750000e-04 2.500000e-04

* Output signals
.save v(vpri_diff) v(vin_dc) v(sw) v(vout) i(Vl_sense) i(Vin_sense)

.options RELTOL=0.001000 ABSTOL=1.000000e-09 VNTOL=1.000000e-06 ITL1=1000 ITL4=1000
.options METHOD=GEAR TRTOL=7.000000
.ic v(vout)=12.000000

.end

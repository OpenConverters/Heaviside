* Isolated Buck-Boost Converter - Generated by OpenMagnetics
* Vin=48V, Vout=12V, f=200kHz, D=19 pct
* Lmag=1000uH, 1 secondaries

* DC Input
Vin vin_dc 0 48

* §8a.5 input-current sense
Vq1_sense vin_dc q1_drain 0

* PWM Switch
Vpwm pwm_ctrl 0 PULSE(0 5 0 1e-08 1e-08 9.5e-07 5e-06)
.model SW1 SW VT=2.5 VH=0.5 RON=0.01 ROFF=1.000000e+06
S1 q1_drain pri_p pwm_ctrl 0 SW1

* Primary current sense
Vpri_sense pri_p pri_in 0

* Coupled Inductor (Primary = flyback-type primary winding)
Lpri pri_in 0 1.000000e-03
Lsec0 0 sec0_in 2.500000e-04
Kpri_sec0 Lpri Lsec0 1

* Diode model
.model DIDEAL D(IS=1.000000e-12 RS=5.000000e-02)

* Primary Output Stage (inverting Buck-Boost; Vout < 0)
Dpri vpri_rect pri_in DIDEAL
Vpri_out_sense vpri_rect vpri_out 0
Cpri vpri_out vpri_out_esr 100u IC=-12
Rpri_esr vpri_out_esr 0 0.1
Rload_pri vpri_out 0 2.4

* Secondary 0 output stage
Rsec0 sec0_in sec0_node 0.01
Dsec0 sec0_node sec0_rect DIDEAL
Vsec_sense0 sec0_rect vout0 0
Cout0 vout0 vout0_esr 100u IC=5
Rout0_esr vout0_esr 0 0.1
Rload0 vout0 0 5

* Magnetizing current probe (continuous triangular waveform)
Bimag 0 imag_p I = I(Lpri) + I(Lsec0)/2.000000
Vimag_sense imag_p 0 0

* Transient Analysis
.tran 2.500000e-08 1.250000e-04 1.000000e-04

* Output signals
.save v(vin_dc) i(Vin) i(Vq1_sense) v(pri_in) i(Vpri_sense) i(Vimag_sense) i(Lpri) v(vpri_out) i(Vpri_out_sense) v(sec0_in) i(Vsec_sense0) v(vout0)

.options RELTOL=0.001000 ABSTOL=1.000000e-09 VNTOL=1.000000e-06 ITL1=1000 ITL4=1000 RSHUNT=1e12 RSERIES=1e-4
.nodeset v(pri_in)=0 v(vpri_out)=-12
.nodeset v(vout0)=5

.end

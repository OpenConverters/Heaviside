* LLC Resonant Converter v3.3 (Separate Ls)
* Half-Bridge
* Vin=48V  fsw=200kHz  outputs=1
* Ls=2.8601uH  Cr=295.215nF  Lm=1000uH
*   output 0: Vout=12V Iout=5A n=2

Vin vin_dc 0 48

.model SW1 SW VT=2.5 VH=0.8 RON=0.01 ROFF=1e+06
.model DIDEAL D(IS=1.000000e-12 RS=5.000000e-02)

Cbus_hi vin_dc mid_point 1u IC=24.000000
Cbus_lo mid_point 0 1u IC=24.000000
Rbal_hi vin_dc mid_point 100k
Rbal_lo mid_point 0 100k
Vpwm_HI pwm_HI 0 PULSE(0 5.000000 0 1.000000e-08 1.000000e-08 1.500000e-06 5.000000e-06)
Vpwm_LO pwm_LO 0 PULSE(0 5.000000 2.500000e-06 1.000000e-08 1.000000e-08 1.500000e-06 5.000000e-06)
Vq1_sense vin_dc qhi_drain 0
SHI qhi_drain sw_node pwm_HI 0 SW1
DHI 0 sw_node DIDEAL
SLO sw_node 0 pwm_LO 0 SW1
DLO sw_node qhi_drain DIDEAL
Rsnub_HI qhi_drain sw_node 10000.000000
Csnub_HI qhi_drain sw_node 1.000000e-10
Rsnub_LO sw_node 0 10000.000000
Csnub_LO sw_node 0 1.000000e-10
Vpri_sense sw_node lr_in 0

* Resonant tank (separate inductor)
Cr lr_in cr_ls 2.952147e-07
Lr cr_ls pri_top 2.860098e-06

* Transformer (k~0.999, pairwise K statements for ngspice compatibility)
Lpri pri_top pri_bot 1.000000e-03
Lsec1_o1 sec_top_sec_o1 sec_ct_o1 2.500000e-04
Lsec2_o1 sec_ct_o1 sec_bot_sec_o1 2.500000e-04
K1 Lpri Lsec1_o1 9.990000e-01
K2 Lpri Lsec2_o1 9.990000e-01
K3 Lsec1_o1 Lsec2_o1 9.990000e-01

Rpri_ret pri_bot mid_point 0.001

Evpri_w vpri_w 0 pri_top pri_bot 1
Evsec1_w_o1 vsec1_w_o1 0 sec_top_sec_o1 sec_ct_o1 1
Evsec2_w_o1 vsec2_w_o1 0 sec_ct_o1 sec_bot_sec_o1 1

.model DRECT D(Is=1e-8 N=0.01 RS=0.01)
* Output 1 rectifier (CT Vout=1.200000e+01V Rload=2.400000e+00)
D1_o1 sec_top_o1 vout_pos_o1 DRECT
D2_o1 sec_bot_o1 vout_pos_o1 DRECT
Rsn1_o1 sec_top_o1 vout_pos_o1 100
Csn1_o1 sec_top_o1 vout_pos_o1 100p
Rsn2_o1 sec_bot_o1 vout_pos_o1 100
Csn2_o1 sec_bot_o1 vout_pos_o1 100p
Vsec1_sense_o1 sec_top_sec_o1 sec_top_o1 0
Vsec2_sense_o1 sec_bot_sec_o1 sec_bot_o1 0
Vsec_sense_o1 sec_ct_o1 vout_neg_o1 0
Vgnd_o1 vout_neg_o1 0 0
Resr_o1 vout_pos_o1 vout_cap_o1 0.05
Cout_o1 vout_cap_o1 vout_neg_o1 4.700000e-05
Rload_o1 vout_cap_o1 vout_neg_o1 2.400000e+00

.ic v(vout_cap_o1)=1.200000e+01 v(cr_ls)=0

.options RELTOL=1.000000e-02 ABSTOL=1.000000e-07 VNTOL=1.000000e-04 ITL1=500 ITL4=500
.options METHOD=GEAR TRTOL=7.000000

.tran 2.500000e-08 4.000000e-05 1.500000e-05 2.500000e-08 UIC

.save v(vin_dc) i(Vin) v(vpri_w) v(pri_top) v(pri_bot) i(Vpri_sense) i(Vq1_sense) v(sw_node) v(mid_point) v(sec_top_o1) v(sec_bot_o1) v(vsec1_w_o1) v(vsec2_w_o1) v(vout_pos_o1) v(vout_cap_o1) i(Vsec1_sense_o1) i(Vsec2_sense_o1) i(Vsec_sense_o1)

.end

* 4-Switch Buck-Boost Converter - Generated by OpenMagnetics
* Vin=48V, Vo=12V, Iout=5A
* Fs=200kHz, L=1000uH, region=BUCK, D_buck=0.263158, D_boost=0
* transitionMode=splitPwm, controlMode=2

* DC Input + sense
Vin vin_dc 0 48
Vin_sense vin_dc vin_p 0

* Switch model
.model SW1 SW VT=2.500000 VH=0.100000 RON=0.050000 RON=0.01 ROFF=1e+06

* Region-aware gate drives (region=BUCK)
Vpwm_q1 pwm_q1 0 PULSE(0 5 0 1.000000e-08 1.000000e-08 1.315789e-06 5.000000e-06)
Vpwm_q2 pwm_q2 0 PULSE(5.000000 0 0 1.000000e-08 1.000000e-08 1.315789e-06 5.000000e-06)
Vpwm_q3 pwm_q3 0 5.000000
Vpwm_q4 pwm_q4 0 0

* Input capacitor
Cin vin_p 0 2.019852e-06 IC=48.000000

* Buck-leg switches (Q1 HS, Q2 LS) + RC snubber on SW1
S_Q1 vin_p sw1 pwm_q1 0 SW1
S_Q2 sw1 0     pwm_q2 0 SW1
Rsnub_sw1 sw1 sn_sw1 10000.000000
Csnub_sw1 sn_sw1 0 1.000000e-10

* Inductor with current sense (Vl_sense in series at the SW1 side)
Vl_sense sw1 l_in 0
L1 l_in l_out 1.000000e-03 IC=5.000000
Bvpri_diff vpri_diff 0 V=V(l_in)-V(l_out)

* Vsw2_sense sense + boost-leg switches (Q3 HS to vout, Q4 LS to 0) + snubber
Vsw2_sense l_out sw2 0
S_Q3 sw2 vout pwm_q3 0 SW1
S_Q4 sw2 0    pwm_q4 0 SW1
Rsnub_sw2 sw2 sn_sw2 10000.000000
Csnub_sw2 sn_sw2 0 1.000000e-10

* Output capacitor + resistive load with Vout_sense
Cout vout 0 4.700000e-05 IC=12.000000
Vout_sense vout out_load 0
Rload out_load 0 2.400000

* Transient analysis (UIC enables .ic)
.tran 2.500000e-08 1.750000e-04 1.450000e-04 UIC

* Output signals
.save v(vpri_diff) v(vin_dc) v(sw1) v(sw2) v(vout) i(Vin_sense) i(Vl_sense) i(Vsw2_sense) i(Vout_sense)

.options RELTOL=0.010000 ABSTOL=1.000000e-07 VNTOL=1.000000e-04 ITL1=500 ITL4=500
.options METHOD=GEAR TRTOL=7.000000
.ic v(vout)=12.000000

.end

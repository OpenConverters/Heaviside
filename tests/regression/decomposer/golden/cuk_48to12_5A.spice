* Cuk Converter (non-isolated V1) - Generated by OpenMagnetics
* Vin=48V, |Vo|=12V (sign: negative), f=200kHz, D=21.7839 pct
* L1=1000uH, L2=31.2864uH, C1=1.77484uF, Co=7.8125uF, Iout=5A

* DC Input + sense
Vin vin_dc 0 48
Vin_sense vin_dc l1_in 0

* L1 input inductor (with DCR)
L1 l1_in l1_dcr_mid 1.000000e-03 ic=1.392544
Rdcr_l1 l1_dcr_mid node_A 0.050000
Vl1_sense node_A node_A_int 0

* PWM low-side switch on node_A
Vpwm pwm_ctrl 0 PULSE(0 5.000000 0 1.000000e-08 1.000000e-08 1.089194e-06 5.000000e-06)
.model SW1 SW VT=2.500000 VH=0.500000
S1 node_A_int 0 pwm_ctrl 0 SW1
Rsnub_s1 node_A_int 0 100.000000
Csnub_s1 node_A_int snub_s1_int 1.000000e-10
Rsnub_s1b snub_s1_int 0 0.001

* C1 coupling cap (with ESR)
Vc1_sense node_A_int node_C 0
C1 node_C node_C_esr 1.774844e-06 ic=61.368421
Rc1_esr node_C_esr node_B 0.005000

Vd_sense d_cath 0 0
* D1 freewheel diode
.model DIDEAL D(IS=1.000000e-12 RS=5.000000e-02)
D1 node_B d_cath DIDEAL
Rsnub_d1 node_B 0 100.000000
Csnub_d1 node_B snub_d1_int 1.000000e-10
Rsnub_d1b snub_d1_int 0 0.001

* L2 output inductor (with DCR)
L2 node_B l2_dcr_mid 3.128645e-05 ic=5.000000
Rdcr_l2 l2_dcr_mid out_sense 0.050000
Vl2_sense out_sense vout_load_node 0

* Output cap (with ESR) and resistive load
Cout vout_load_node co_esr 7.812500e-06 ic=-12.000000
Rco_esr co_esr 0 0.005000
Vout_sense vout_load_node vout_load 0
Rload vout_load 0 2.400000

* Bridge / switch-node probe
Bsw sw_probe 0 V=V(node_A)
Bvpri_diff vpri_diff 0 V=V(l1_in)-V(node_A)

* Transient Analysis (UIC enables .ic above)
.tran 2.500000e-08 2.750000e-04 2.500000e-04 UIC

* Output signals
.save v(vpri_diff) v(vin_dc) v(node_A) v(node_B) v(sw_probe) v(vout_load_node) i(Vin_sense) i(Vl1_sense) i(Vc1_sense) i(Vl2_sense) i(Vd_sense) i(Vout_sense)

.options RELTOL=0.010000 ABSTOL=1.000000e-07 VNTOL=1.000000e-04 ITL1=500 ITL4=500
.options METHOD=GEAR TRTOL=7.000000
.end

* Zeta Converter (V1 uncoupled) - Generated by OpenMagnetics
* Vin=48V, Vo=12V, f=200kHz, D=21.7839 pct
* L1=1000uH, L2=34.8542uH, Cc=9.07662uF, Co=7.8125uF, Iout=5A

* DC Input + sense
Vin vin_dc 0 48
Vin_sense vin_dc sw_top 0

* High-side switch S1 (PFET-equivalent ideal SW)
Vpwm pwm_ctrl 0 PULSE(0 5 0 1.000000e-08 1.000000e-08 1.089194e-06 5.000000e-06)
.model SW1 SW VT=2.500000 VH=0.500000
S1 sw_top node_SW pwm_ctrl 0 SW1
Rsnub_s1 sw_top node_SW 10000.000000
Csnub_s1 sw_top snub_s1_int 1.000000e-10
Rsnub_s1b snub_s1_int node_SW 0.001000

* L1 magnetizing inductor (top at node_SW; with DCR)
Vl1_sense node_SW l1_top 0
L1 l1_top l1_dcr_mid 1.000000e-03 ic=1.392544
Rdcr_l1 l1_dcr_mid 0 0.050000

* Cc coupling cap (with ESR; +plate at node_X side, IC=+Vo)
Vc_sense_sw node_SW cc_right_esr 0
Rcc_esr cc_right_esr cc_right 0.005000
Cc cc_left cc_right 9.076615e-06 ic=12.000000
Vc_sense_x cc_left node_X 0

* D1 catch diode (anode=GND, cathode=node_X)
.model DIDEAL D(IS=1.000000e-12 RS=5.000000e-02)
Vrect_sense rect_in node_X 0
D1 0 rect_in DIDEAL
Rsnub_d1 0 node_X 10000.000000
Csnub_d1 node_X snub_d1_int 1.000000e-10
Rsnub_d1b snub_d1_int 0 0.001000

* L2 output inductor (top at node_X; with DCR)
Vl2_sense node_X l2_top 0
L2 l2_top l2_dcr_mid 3.485420e-05 ic=5.000000
Rdcr_l2 l2_dcr_mid vout 0.050000

* Output cap (with ESR) and resistive load
Cout vout co_esr 7.812500e-06 ic=12.000000
Rco_esr co_esr 0 0.005000
Vout_sense vout vout_load 0
Rload vout_load 0 2.400000

* Bridge / switch-node probe
Bsw sw_probe 0 V=V(node_SW)
Bvpri_diff vpri_diff 0 V=V(l1_top)

* Transient Analysis (UIC enables .ic above)
.tran 2.500000e-08 2.750000e-04 2.500000e-04 UIC

* Output signals
.save v(vpri_diff) v(vin_dc) v(node_SW) v(node_X) v(sw_probe) v(vout) i(Vin_sense) i(Vl1_sense) i(Vc_sense_sw) i(Vl2_sense) i(Vrect_sense) i(Vout_sense)

.options RELTOL=0.010000 ABSTOL=1.000000e-07 VNTOL=1.000000e-04 ITL1=500 ITL4=500
.options METHOD=GEAR TRTOL=7.000000
.end
